*** SPICE deck for cell common-source-amp{lay} from library Analog_Circuit_CMOS_Chip
*** Created on Tue May 12, 2026 15:42:17
*** Last revised on Wed May 13, 2026 09:23:50
*** Written on Wed May 13, 2026 09:24:34 by Electric VLSI Design System, version 9.08
*** Layout tech: mocmos, foundry MOSIS
*** UC SPICE *** , MIN_RESIST 4.0, MIN_CAPAC 0.1FF

*** TOP LEVEL CELL: common-source-amp{lay}
Mnmos_0 Vout Vin 0 0 NMOS L=0.4U W=4U AS=7.2P AD=3.25P PS=16.6U PD=7.6U
Mpmos_0 Vout Vout vdd vdd PMOS L=0.4U W=1U AS=3.3P AD=3.25P PS=10.6U PD=7.6U

* Spice Code nodes in cell cell 'common-source-amp{lay}'
vdd vdd 0 DC 5
vin vin 0 DC 0.9 AC 1
.ac dec 100 100 10g
.include "C:\C5_models.txt"
.END
