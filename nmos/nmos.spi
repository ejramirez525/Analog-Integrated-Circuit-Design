*** SPICE deck for cell nmos{lay} from library Analog_Circuit_CMOS_Chip
*** Created on Thu May 07, 2026 20:41:29
*** Last revised on Wed May 13, 2026 09:09:05
*** Written on Wed May 13, 2026 09:10:14 by Electric VLSI Design System, version 9.08
*** Layout tech: mocmos, foundry MOSIS
*** UC SPICE *** , MIN_RESIST 4.0, MIN_CAPAC 0.1FF
*** WARNING: no ground connection for N-transistor wells in cell 'nmos{lay}'

*** TOP LEVEL CELL: nmos{lay}
Mnmos_0 s g d gnd NMOS L=0.4U W=4U AS=5.2P AD=5.2P PS=10.6U PD=10.6U

* Spice Code nodes in cell cell 'nmos{lay}'
vs s 0 DC 0
vb b 0 DC 0
vg g 0 DC 0
vd d 0 DC 0
.dc vd 0 5 1m vg 0 5 1
.include "C:\C5_models.txt"
.END
