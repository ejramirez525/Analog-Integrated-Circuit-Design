*** SPICE deck for cell ring-oscillator{lay} from library Analog_Circuit_CMOS_Chip
*** Created on Tue May 12, 2026 21:10:13
*** Last revised on Wed May 13, 2026 09:49:35
*** Written on Wed May 13, 2026 09:52:10 by Electric VLSI Design System, version 9.08
*** Layout tech: mocmos, foundry MOSIS
*** UC SPICE *** , MIN_RESIST 4.0, MIN_CAPAC 0.1FF

*** SUBCIRCUIT Analog_Circuit_CMOS_Chip__cmos-inverter FROM CELL cmos-inverter{lay}
.SUBCKT Analog_Circuit_CMOS_Chip__cmos-inverter 0 vdd Vin Vout
Mnmos_1 Vout Vin 0 0 NMOS L=0.4U W=2U AS=6.6P AD=3.9P PS=16.6U PD=8.6U
Mpmos_0 Vout Vin vdd vdd PMOS L=0.4U W=4U AS=9.2P AD=3.9P PS=20.6U PD=8.6U

* Spice Code nodes in cell cell 'cmos-inverter{lay}'
*vdd vdd 0 DC 5
*vgnd gnd 0 DC 0
*vin vin 0 pulse (0 5 0 1n 1n 10n 20n)
*.include "C:\C5_models.txt"
*.tran 1n 100n
.ENDS Analog_Circuit_CMOS_Chip__cmos-inverter

*** TOP LEVEL CELL: ring-oscillator{lay}
XcmosInve_0 0 vdd net_3 net_5 Analog_Circuit_CMOS_Chip__cmos-inverter
XcmosInve_1 0 vdd net_5 osc_out Analog_Circuit_CMOS_Chip__cmos-inverter
XcmosInve_2 0 vdd osc_out net_3 Analog_Circuit_CMOS_Chip__cmos-inverter

* Spice Code nodes in cell cell 'ring-oscillator{lay}'
vdd vdd 0 DC 5
.tran 0 30n
.include "C:\C5_models.txt"
.END
